* 4-bit r-2r ladder dac network
Vb3 b3 0 1.8
Vb2 b2 0 0
Vb1 b1 0 1.8
Vb0 b0 0 0
R1 b0 n0 20k
R2 b1 n1 20k
R3 b2 n2 20k
R4 b3 n3 20k
Rt n0 0 20k
Rs0 n0 n1 10k
Rs1 n1 n2 10k
Rs2 n2 n3 10k
.end
