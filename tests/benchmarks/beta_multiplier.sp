* beta-multiplier (constant-gm) bias reference
Vdd vdd 0 1.8
M1 n1 np vdd vdd pch W=10u L=1u
M2 np np vdd vdd pch W=10u L=1u
M3 n1 n1 0 0 nch W=5u L=1u
M4 np n1 ns 0 nch W=20u L=1u
Rs ns 0 10k
.end
