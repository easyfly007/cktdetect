* class-ab push-pull output stage with split gate drives
Vdd vdd 0 1.8
Vin sig 0 DC 0.9 AC 1
R1 sig gp 1k
R2 sig gn 1k
Mp out gp vdd vdd pch W=40u L=0.5u
Mn out gn 0 0 nch W=20u L=0.5u
Rl out 0 1k
.end
