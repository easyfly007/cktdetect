* series rlc bandpass: series l + series c into resistive load
Vin in 0 AC 1
L1 in n1 10n
C1 n1 out 100p
Rl out 0 50
.end
