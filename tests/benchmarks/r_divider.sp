* resistive divider
Vin in 0 5
R1 in mid 30k
R2 mid 0 10k
.end
