* third-order lc lowpass pi filter
Vin in 0 AC 1
Rs in n1 50
C1 n1 0 100p
L1 n1 n2 10n
C2 n2 0 100p
Rl n2 0 50
.end
