* first-order rc highpass
Vin in 0 AC 1
C1 in out 10n
R1 out 0 10k
.end
