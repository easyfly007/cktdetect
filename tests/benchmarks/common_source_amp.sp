* common source amplifier with current-source load
Vdd vdd 0 1.8
Vb nb 0 1.0
Vin in 0 DC 0.9 AC 1
M1 out in 0 0 nch W=10u L=0.5u
M2 out nb vdd vdd pch W=20u L=1u
CL out 0 1p
.end
